** sch_path: /foss/designs/lab2/DAC_CORE_5bit.sch
.subckt DAC_CORE_5bit VDD DAC_REF I_DAC b[4] b[3] b[2] b[1] b[0]
*.PININFO DAC_REF:B b[4:0]:I VDD:B I_DAC:O
XM1 net2 DAC_REF VDD VDD sky130_fd_pr__pfet_01v8 L=5 W=3.5 nf=1 m=2
XM2 net3 DAC_REF VDD VDD sky130_fd_pr__pfet_01v8 L=5 W=3.5 nf=1 m=4
XM3 net4 DAC_REF VDD VDD sky130_fd_pr__pfet_01v8 L=5 W=3.5 nf=1 m=8
XM4 net5 DAC_REF VDD VDD sky130_fd_pr__pfet_01v8 L=5 W=3.5 nf=1 m=16
XM0 net1 DAC_REF VDD VDD sky130_fd_pr__pfet_01v8 L=5 W=3.5 nf=1
XMK0 I_DAC b[0] net1 VDD sky130_fd_pr__pfet_01v8 L=0.15 W=0.42 nf=1
XMK1 I_DAC b[1] net2 VDD sky130_fd_pr__pfet_01v8 L=0.15 W=0.42 nf=1 m=2
XMK2 I_DAC b[2] net3 VDD sky130_fd_pr__pfet_01v8 L=0.15 W=0.42 nf=1 m=4
XMK3 I_DAC b[3] net4 VDD sky130_fd_pr__pfet_01v8 L=0.15 W=0.42 nf=1 m=8
XMK4 I_DAC b[4] net5 VDD sky130_fd_pr__pfet_01v8 L=0.15 W=0.42 nf=1 m=16
.ends
