** sch_path: /foss/designs/lab2/xschem/DAC_CORE_5bit.sch
.subckt DAC_CORE_5bit VDD DAC_REF I_DAC b[4] b[3] b[2] b[1] b[0]
*.PININFO DAC_REF:B b[4:0]:I VDD:B I_DAC:O
XM1 M1_C DAC_REF VDD VDD sky130_fd_pr__pfet_01v8 L=5 W=3.5 nf=1 m=2
XM2 M2_C DAC_REF VDD VDD sky130_fd_pr__pfet_01v8 L=5 W=3.5 nf=1 m=4
XM3 M3_C DAC_REF VDD VDD sky130_fd_pr__pfet_01v8 L=5 W=3.5 nf=1 m=8
XM4 M4_C DAC_REF VDD VDD sky130_fd_pr__pfet_01v8 L=5 W=3.5 nf=1 m=16
XM0 M0_C DAC_REF VDD VDD sky130_fd_pr__pfet_01v8 L=5 W=3.5 nf=1
XMK0 I_DAC b[0] M0_C VDD sky130_fd_pr__pfet_01v8 L=0.15 W=0.42 nf=1
XMK1 I_DAC b[1] M1_C VDD sky130_fd_pr__pfet_01v8 L=0.15 W=0.42 nf=1 m=2
XMK2 I_DAC b[2] M2_C VDD sky130_fd_pr__pfet_01v8 L=0.15 W=0.42 nf=1 m=4
XMK3 I_DAC b[3] M3_C VDD sky130_fd_pr__pfet_01v8 L=0.15 W=0.42 nf=1 m=8
XMK4 I_DAC b[4] M4_C VDD sky130_fd_pr__pfet_01v8 L=0.15 W=0.42 nf=1 m=16
XMD VDD DAC_REF VDD VDD sky130_fd_pr__pfet_01v8 L=5 W=3.5 nf=1 m=32
XMKD I_DAC b[1] I_DAC VDD sky130_fd_pr__pfet_01v8 L=0.15 W=0.42 nf=1
.ends
