* Extracted by KLayout with SKY130 LVS runset on : 13/08/2026 15:12

* cell DAC_CORE_5bit
* pin B[0]
* pin B[1]
* pin B[2]
* pin B[3]
* pin B[4]
* pin DAC_REF
* pin I_DAC
* pin VDD
.SUBCKT DAC_CORE_5bit_pex B[0] B[1] B[2] B[3] B[4] DAC_REF I_DAC VDD
* device instance $1 r0 *1 34.05,14.53 sky130_fd_pr__pfet_01v8
XM$1 VDD DAC_REF \$2 VDD sky130_fd_pr__pfet_01v8 L=5000000 W=14000000
+ AS=4.2e+12 AD=4.2e+12 PS=30400000 PD=30400000
* device instance $5 r0 *1 27.8,18.79 sky130_fd_pr__pfet_01v8
XM$5 VDD DAC_REF \$3 VDD sky130_fd_pr__pfet_01v8 L=5000000 W=7000000 AS=2.1e+12
+ AD=2.1e+12 PS=15200000 PD=15200000
* device instance $7 r0 *1 2.8,1.75 sky130_fd_pr__pfet_01v8
XM$7 VDD DAC_REF VDD VDD sky130_fd_pr__pfet_01v8 L=5000000 W=112000000
+ AS=3.36e+13 AD=3.36e+13 PS=243200000 PD=243200000
* device instance $39 r0 *1 46.55,18.79 sky130_fd_pr__pfet_01v8
XM$39 VDD DAC_REF \$39 VDD sky130_fd_pr__pfet_01v8 L=5000000 W=56000000
+ AS=1.68e+13 AD=1.68e+13 PS=121600000 PD=121600000
* device instance $47 r0 *1 34.05,23.05 sky130_fd_pr__pfet_01v8
XM$47 VDD DAC_REF \$11 VDD sky130_fd_pr__pfet_01v8 L=5000000 W=28000000
+ AS=8.4e+12 AD=8.4e+12 PS=60800000 PD=60800000
* device instance $51 r0 *1 27.8,14.53 sky130_fd_pr__pfet_01v8
XM$51 VDD DAC_REF \$12 VDD sky130_fd_pr__pfet_01v8 L=5000000 W=3500000
+ AS=1.05e+12 AD=1.05e+12 PS=7600000 PD=7600000
* device instance $64 m90 *1 -8.945,13 sky130_fd_pr__pfet_01v8
XM$64 I_DAC B[1] I_DAC VDD sky130_fd_pr__pfet_01v8 L=150000 W=420000
+ AS=126000000000 AD=126000000000 PS=1440000 PD=1440000
* device instance $65 m90 *1 -8.945,24.9 sky130_fd_pr__pfet_01v8
XM$65 I_DAC B[4] \$39 VDD sky130_fd_pr__pfet_01v8 L=150000 W=6720000
+ AS=2.016e+12 AD=2.016e+12 PS=23040000 PD=23040000
* device instance $69 m90 *1 -8.945,18.1 sky130_fd_pr__pfet_01v8
XM$69 I_DAC B[3] \$11 VDD sky130_fd_pr__pfet_01v8 L=150000 W=3360000
+ AS=1.008e+12 AD=1.008e+12 PS=11520000 PD=11520000
* device instance $71 m90 *1 -8.945,14.7 sky130_fd_pr__pfet_01v8
XM$71 I_DAC B[2] \$2 VDD sky130_fd_pr__pfet_01v8 L=150000 W=1680000
+ AS=504000000000 AD=504000000000 PS=5760000 PD=5760000
* device instance $79 m90 *1 -6.145,13 sky130_fd_pr__pfet_01v8
XM$79 I_DAC B[1] \$3 VDD sky130_fd_pr__pfet_01v8 L=150000 W=840000
+ AS=252000000000 AD=252000000000 PS=2880000 PD=2880000
* device instance $80 r0 *1 -4.745,13 sky130_fd_pr__pfet_01v8
XM$80 I_DAC B[0] \$12 VDD sky130_fd_pr__pfet_01v8 L=150000 W=420000
+ AS=126000000000 AD=126000000000 PS=1440000 PD=1440000
.ENDS DAC_CORE_5bit_pex
