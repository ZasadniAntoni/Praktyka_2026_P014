* NGSPICE file created from DAC_CORE_5bit.ext - technology: sky130A

.subckt DAC_BASE_MK a_90_0# a_60_n40# a_0_0# w_n65_n76# VSUBS
X0 a_90_0# a_60_n40# a_0_0# w_n65_n76# sky130_fd_pr__pfet_01v8 ad=0.126 pd=1.44 as=0.126 ps=1.44 w=0.42 l=0.15
C0 a_0_0# VSUBS 0.21855f
C1 w_n65_n76# VSUBS 0.2856f
.ends

.subckt DAC_BASE_MCS a_1060_0# a_0_0# w_n65_n76# a_60_n76# VSUBS
X0 a_1060_0# a_60_n76# a_0_0# w_n65_n76# sky130_fd_pr__pfet_01v8 ad=1.05 pd=7.6 as=1.05 ps=7.6 w=3.5 l=5
C0 w_n65_n76# a_0_0# 0.11812f
C1 a_60_n76# w_n65_n76# 0.45276f
C2 a_60_n76# a_0_0# 0.31778f
C3 a_60_n76# a_1060_0# 0.26704f
C4 a_1060_0# VSUBS 0.53162f
C5 a_0_0# VSUBS 0.63561f
C6 w_n65_n76# VSUBS 3.195f
.ends

.subckt DAC_CORE_5bit_pex VDD DAC_REF I_DAC b[4] b[3] b[2] b[1] b[0]
XDAC_BASE_MK_0[0] I_DAC B[1] I_DAC w_n2049_2482# VSUBS DAC_BASE_MK
XDAC_BASE_MK_0[1] m2_n334_4318# B[2] I_DAC w_n2049_2482# VSUBS DAC_BASE_MK
XDAC_BASE_MK_0[2] m2_624_2286# B[3] I_DAC w_n2049_2482# VSUBS DAC_BASE_MK
XDAC_BASE_MK_0[3] m2_624_2286# B[3] I_DAC w_n2049_2482# VSUBS DAC_BASE_MK
XDAC_BASE_MK_0[4] m1_8303_878# B[4] I_DAC w_n2049_2482# VSUBS DAC_BASE_MK
XDAC_BASE_MK_0[5] m1_8303_878# B[4] I_DAC w_n2049_2482# VSUBS DAC_BASE_MK
XDAC_BASE_MK_0[6] m1_8303_878# B[4] I_DAC w_n2049_2482# VSUBS DAC_BASE_MK
XDAC_BASE_MK_0[7] m1_8303_878# B[4] I_DAC w_n2049_2482# VSUBS DAC_BASE_MK
XDAC_BASE_MK_1[0] m2_348_1798# B[1] I_DAC w_n2049_2482# VSUBS DAC_BASE_MK
XDAC_BASE_MK_1[1] m2_n334_4318# B[2] I_DAC w_n2049_2482# VSUBS DAC_BASE_MK
XDAC_BASE_MK_1[2] m2_624_2286# B[3] I_DAC w_n2049_2482# VSUBS DAC_BASE_MK
XDAC_BASE_MK_1[3] m2_624_2286# B[3] I_DAC w_n2049_2482# VSUBS DAC_BASE_MK
XDAC_BASE_MK_1[4] m1_8303_878# B[4] I_DAC w_n2049_2482# VSUBS DAC_BASE_MK
XDAC_BASE_MK_1[5] m1_8303_878# B[4] I_DAC w_n2049_2482# VSUBS DAC_BASE_MK
XDAC_BASE_MK_1[6] m1_8303_878# B[4] I_DAC w_n2049_2482# VSUBS DAC_BASE_MK
XDAC_BASE_MK_1[7] m1_8303_878# B[4] I_DAC w_n2049_2482# VSUBS DAC_BASE_MK
XDAC_BASE_MK_2[0] m2_348_1798# B[1] I_DAC w_n2049_2482# VSUBS DAC_BASE_MK
XDAC_BASE_MK_2[1] m2_n334_4318# B[2] I_DAC w_n2049_2482# VSUBS DAC_BASE_MK
XDAC_BASE_MK_2[2] m2_624_2286# B[3] I_DAC w_n2049_2482# VSUBS DAC_BASE_MK
XDAC_BASE_MK_2[3] m2_624_2286# B[3] I_DAC w_n2049_2482# VSUBS DAC_BASE_MK
XDAC_BASE_MK_2[4] m1_8303_878# B[4] I_DAC w_n2049_2482# VSUBS DAC_BASE_MK
XDAC_BASE_MK_2[5] m1_8303_878# B[4] I_DAC w_n2049_2482# VSUBS DAC_BASE_MK
XDAC_BASE_MK_2[6] m1_8303_878# B[4] I_DAC w_n2049_2482# VSUBS DAC_BASE_MK
XDAC_BASE_MK_2[7] m1_8303_878# B[4] I_DAC w_n2049_2482# VSUBS DAC_BASE_MK
XDAC_BASE_MK_3[0] m2_n837_2268# B[0] I_DAC w_n2049_2482# VSUBS DAC_BASE_MK
XDAC_BASE_MK_3[1] m2_n334_4318# B[2] I_DAC w_n2049_2482# VSUBS DAC_BASE_MK
XDAC_BASE_MK_3[2] m2_624_2286# B[3] I_DAC w_n2049_2482# VSUBS DAC_BASE_MK
XDAC_BASE_MK_3[3] m2_624_2286# B[3] I_DAC w_n2049_2482# VSUBS DAC_BASE_MK
XDAC_BASE_MK_3[4] m1_8303_878# B[4] I_DAC w_n2049_2482# VSUBS DAC_BASE_MK
XDAC_BASE_MK_3[5] m1_8303_878# B[4] I_DAC w_n2049_2482# VSUBS DAC_BASE_MK
XDAC_BASE_MK_3[6] m1_8303_878# B[4] I_DAC w_n2049_2482# VSUBS DAC_BASE_MK
XDAC_BASE_MK_3[7] m1_8303_878# B[4] I_DAC w_n2049_2482# VSUBS DAC_BASE_MK
XDAC_BASE_MCS_0[0|0] VDD VDD w_n165_n176# DAC_REF VSUBS DAC_BASE_MCS
XDAC_BASE_MCS_0[1|0] VDD VDD w_n165_n176# DAC_REF VSUBS DAC_BASE_MCS
XDAC_BASE_MCS_0[2|0] VDD VDD w_n165_n176# DAC_REF VSUBS DAC_BASE_MCS
XDAC_BASE_MCS_0[3|0] VDD VDD w_n165_n176# DAC_REF VSUBS DAC_BASE_MCS
XDAC_BASE_MCS_0[4|0] VDD VDD w_n165_n176# DAC_REF VSUBS DAC_BASE_MCS
XDAC_BASE_MCS_0[5|0] VDD VDD w_n165_n176# DAC_REF VSUBS DAC_BASE_MCS
XDAC_BASE_MCS_0[6|0] VDD VDD w_n165_n176# DAC_REF VSUBS DAC_BASE_MCS
XDAC_BASE_MCS_0[0|1] VDD VDD w_n165_n176# DAC_REF VSUBS DAC_BASE_MCS
XDAC_BASE_MCS_0[1|1] VDD VDD w_n165_n176# DAC_REF VSUBS DAC_BASE_MCS
XDAC_BASE_MCS_0[2|1] m1_8303_878# VDD w_n165_n176# DAC_REF VSUBS DAC_BASE_MCS
XDAC_BASE_MCS_0[3|1] m1_8303_878# VDD w_n165_n176# DAC_REF VSUBS DAC_BASE_MCS
XDAC_BASE_MCS_0[4|1] m1_8303_878# VDD w_n165_n176# DAC_REF VSUBS DAC_BASE_MCS
XDAC_BASE_MCS_0[5|1] VDD VDD w_n165_n176# DAC_REF VSUBS DAC_BASE_MCS
XDAC_BASE_MCS_0[6|1] VDD VDD w_n165_n176# DAC_REF VSUBS DAC_BASE_MCS
XDAC_BASE_MCS_0[0|2] VDD VDD w_n165_n176# DAC_REF VSUBS DAC_BASE_MCS
XDAC_BASE_MCS_0[1|2] m1_8303_878# VDD w_n165_n176# DAC_REF VSUBS DAC_BASE_MCS
XDAC_BASE_MCS_0[2|2] m1_8303_878# VDD w_n165_n176# DAC_REF VSUBS DAC_BASE_MCS
XDAC_BASE_MCS_0[3|2] m1_8303_878# VDD w_n165_n176# DAC_REF VSUBS DAC_BASE_MCS
XDAC_BASE_MCS_0[4|2] m1_8303_878# VDD w_n165_n176# DAC_REF VSUBS DAC_BASE_MCS
XDAC_BASE_MCS_0[5|2] m1_8303_878# VDD w_n165_n176# DAC_REF VSUBS DAC_BASE_MCS
XDAC_BASE_MCS_0[6|2] VDD VDD w_n165_n176# DAC_REF VSUBS DAC_BASE_MCS
XDAC_BASE_MCS_0[0|3] VDD VDD w_n165_n176# DAC_REF VSUBS DAC_BASE_MCS
XDAC_BASE_MCS_0[1|3] m2_624_2286# VDD w_n165_n176# DAC_REF VSUBS DAC_BASE_MCS
XDAC_BASE_MCS_0[2|3] m2_624_2286# VDD w_n165_n176# DAC_REF VSUBS DAC_BASE_MCS
XDAC_BASE_MCS_0[3|3] m2_n334_4318# VDD w_n165_n176# DAC_REF VSUBS DAC_BASE_MCS
XDAC_BASE_MCS_0[4|3] m2_624_2286# VDD w_n165_n176# DAC_REF VSUBS DAC_BASE_MCS
XDAC_BASE_MCS_0[5|3] m2_624_2286# VDD w_n165_n176# DAC_REF VSUBS DAC_BASE_MCS
XDAC_BASE_MCS_0[6|3] VDD VDD w_n165_n176# DAC_REF VSUBS DAC_BASE_MCS
XDAC_BASE_MCS_0[0|4] VDD VDD w_n165_n176# DAC_REF VSUBS DAC_BASE_MCS
XDAC_BASE_MCS_0[1|4] m2_n334_4318# VDD w_n165_n176# DAC_REF VSUBS DAC_BASE_MCS
XDAC_BASE_MCS_0[2|4] m2_348_1798# VDD w_n165_n176# DAC_REF VSUBS DAC_BASE_MCS
XDAC_BASE_MCS_0[3|4] m2_n837_2268# VDD w_n165_n176# DAC_REF VSUBS DAC_BASE_MCS
XDAC_BASE_MCS_0[4|4] m2_348_1798# VDD w_n165_n176# DAC_REF VSUBS DAC_BASE_MCS
XDAC_BASE_MCS_0[5|4] m2_n334_4318# VDD w_n165_n176# DAC_REF VSUBS DAC_BASE_MCS
XDAC_BASE_MCS_0[6|4] VDD VDD w_n165_n176# DAC_REF VSUBS DAC_BASE_MCS
XDAC_BASE_MCS_0[0|5] VDD VDD w_n165_n176# DAC_REF VSUBS DAC_BASE_MCS
XDAC_BASE_MCS_0[1|5] m2_624_2286# VDD w_n165_n176# DAC_REF VSUBS DAC_BASE_MCS
XDAC_BASE_MCS_0[2|5] m2_624_2286# VDD w_n165_n176# DAC_REF VSUBS DAC_BASE_MCS
XDAC_BASE_MCS_0[3|5] m2_n334_4318# VDD w_n165_n176# DAC_REF VSUBS DAC_BASE_MCS
XDAC_BASE_MCS_0[4|5] m2_624_2286# VDD w_n165_n176# DAC_REF VSUBS DAC_BASE_MCS
XDAC_BASE_MCS_0[5|5] m2_624_2286# VDD w_n165_n176# DAC_REF VSUBS DAC_BASE_MCS
XDAC_BASE_MCS_0[6|5] VDD VDD w_n165_n176# DAC_REF VSUBS DAC_BASE_MCS
XDAC_BASE_MCS_0[0|6] VDD VDD w_n165_n176# DAC_REF VSUBS DAC_BASE_MCS
XDAC_BASE_MCS_0[1|6] m1_8303_878# VDD w_n165_n176# DAC_REF VSUBS DAC_BASE_MCS
XDAC_BASE_MCS_0[2|6] m1_8303_878# VDD w_n165_n176# DAC_REF VSUBS DAC_BASE_MCS
XDAC_BASE_MCS_0[3|6] m1_8303_878# VDD w_n165_n176# DAC_REF VSUBS DAC_BASE_MCS
XDAC_BASE_MCS_0[4|6] m1_8303_878# VDD w_n165_n176# DAC_REF VSUBS DAC_BASE_MCS
XDAC_BASE_MCS_0[5|6] m1_8303_878# VDD w_n165_n176# DAC_REF VSUBS DAC_BASE_MCS
XDAC_BASE_MCS_0[6|6] VDD VDD w_n165_n176# DAC_REF VSUBS DAC_BASE_MCS
XDAC_BASE_MCS_0[0|7] VDD VDD w_n165_n176# DAC_REF VSUBS DAC_BASE_MCS
XDAC_BASE_MCS_0[1|7] VDD VDD w_n165_n176# DAC_REF VSUBS DAC_BASE_MCS
XDAC_BASE_MCS_0[2|7] m1_8303_878# VDD w_n165_n176# DAC_REF VSUBS DAC_BASE_MCS
XDAC_BASE_MCS_0[3|7] m1_8303_878# VDD w_n165_n176# DAC_REF VSUBS DAC_BASE_MCS
XDAC_BASE_MCS_0[4|7] m1_8303_878# VDD w_n165_n176# DAC_REF VSUBS DAC_BASE_MCS
XDAC_BASE_MCS_0[5|7] VDD VDD w_n165_n176# DAC_REF VSUBS DAC_BASE_MCS
XDAC_BASE_MCS_0[6|7] VDD VDD w_n165_n176# DAC_REF VSUBS DAC_BASE_MCS
XDAC_BASE_MCS_0[0|8] VDD VDD w_n165_n176# DAC_REF VSUBS DAC_BASE_MCS
XDAC_BASE_MCS_0[1|8] VDD VDD w_n165_n176# DAC_REF VSUBS DAC_BASE_MCS
XDAC_BASE_MCS_0[2|8] VDD VDD w_n165_n176# DAC_REF VSUBS DAC_BASE_MCS
XDAC_BASE_MCS_0[3|8] VDD VDD w_n165_n176# DAC_REF VSUBS DAC_BASE_MCS
XDAC_BASE_MCS_0[4|8] VDD VDD w_n165_n176# DAC_REF VSUBS DAC_BASE_MCS
XDAC_BASE_MCS_0[5|8] VDD VDD w_n165_n176# DAC_REF VSUBS DAC_BASE_MCS
XDAC_BASE_MCS_0[6|8] VDD VDD w_n165_n176# DAC_REF VSUBS DAC_BASE_MCS
C0 m2_n334_4318# m2_624_2286# 2.09633f
C1 w_n2049_2482# B[3] 0.39117f
C2 m2_348_1798# DAC_REF 3.17387f
C3 B[2] m2_624_2286# 0.31662f
C4 w_n165_n176# m2_n334_4318# 0.18217f
C5 B[0] m2_n837_2268# 0.15082f
C6 w_n2049_2482# B[1] 0.13823f
C7 w_n165_n176# m2_624_2286# 0.36345f
C8 m1_8303_878# m2_348_1798# 0.60453f
C9 w_n2049_2482# I_DAC 0.35342f
C10 VDD m2_348_1798# 2.09019f
C11 m2_n334_4318# DAC_REF 5.46001f
C12 I_DAC m2_n837_2268# 0.12621f
C13 B[0] I_DAC 0.50686f
C14 m2_624_2286# DAC_REF 5.4881f
C15 B[3] I_DAC 0.50626f
C16 m2_n334_4318# m1_8303_878# 1.03893f
C17 w_n165_n176# DAC_REF 12.65453f
C18 m2_n334_4318# VDD 4.70786f
C19 B[1] I_DAC 0.25161f
C20 B[2] VDD 0.12987f
C21 m1_8303_878# m2_624_2286# 1.45328f
C22 m2_624_2286# VDD 6.57273f
C23 m2_n837_2268# m2_348_1798# 0.90037f
C24 w_n165_n176# m1_8303_878# 0.53242f
C25 w_n165_n176# VDD 8.96226f
C26 B[0] m2_348_1798# 0.25655f
C27 w_n2049_2482# m2_n334_4318# 0.13544f
C28 B[1] m2_348_1798# 0.11802f
C29 w_n2049_2482# B[2] 0.19233f
C30 w_n2049_2482# m2_624_2286# 0.32523f
C31 m2_n334_4318# m2_n837_2268# 0.42144f
C32 m1_8303_878# DAC_REF 9.0517f
C33 I_DAC m2_348_1798# 0.26366f
C34 VDD DAC_REF 11.45131f
C35 B[4] m1_8303_878# 3.71969f
C36 B[0] m2_n334_4318# 0.11452f
C37 B[4] VDD 0.6983f
C38 m2_n837_2268# m2_624_2286# 1.13868f
C39 m2_n334_4318# B[1] 0.2104f
C40 m1_8303_878# VDD 13.57225f
C41 B[3] m2_624_2286# 1.56154f
C42 m2_n334_4318# I_DAC 0.27082f
C43 B[4] w_n2049_2482# 0.75109f
C44 I_DAC B[2] 0.25314f
C45 I_DAC m2_624_2286# 0.72552f
C46 m2_n837_2268# DAC_REF 1.23945f
C47 w_n2049_2482# m1_8303_878# 0.71604f
C48 w_n2049_2482# VDD 1.96603f
C49 B[4] B[3] 0.13538f
C50 m1_8303_878# m2_n837_2268# 0.60227f
C51 m2_n334_4318# m2_348_1798# 0.87879f
C52 m2_n837_2268# VDD 1.71184f
C53 B[0] VDD 0.75127f
C54 m2_624_2286# m2_348_1798# 1.94826f
C55 B[3] m1_8303_878# 0.37821f
C56 B[3] VDD 0.23279f
C57 w_n165_n176# m2_348_1798# 0.10415f
C58 B[4] I_DAC 0.95808f
C59 B[1] VDD 0.11265f
C60 m1_8303_878# I_DAC 1.55068f
C61 I_DAC VDD 1.3383f
C62 m2_n334_4318# B[2] 0.4998f
C63 B[0] VSUBS 0.45897f
C64 m2_348_1798# VSUBS -0.54359f
C65 B[4] VSUBS -1.5238f
C66 B[3] VSUBS -0.6872f
C67 B[2] VSUBS -0.35651f
C68 B[1] VSUBS -0.27446f
C69 w_n165_n176# VSUBS -0.15168p
C70 VDD VSUBS -23.90577f
C71 DAC_REF VSUBS -32.0523f
C72 m2_n837_2268# VSUBS -0.30587f
C73 m2_624_2286# VSUBS -2.22482f
C74 m1_8303_878# VSUBS -1.68075f
C75 m2_n334_4318# VSUBS -1.04514f
C76 I_DAC VSUBS -4.9283f
C77 w_n2049_2482# VSUBS 2.5092f
.ends
