.subckt DAC_CORE_5bit VDD VSS
.ends
.end
